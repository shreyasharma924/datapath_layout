ADE simulation setup
Run mode: Single Run, Sweeps and Corners
Tests:
  mp_datapath_transmission_gate_1: mp_datapath/transmission_gate/schematic, simulator spectre
