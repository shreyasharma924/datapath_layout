ADE simulation setup
Test mp_datapath_transmission_gate_1: mp_datapath/transmission_gate/schematic, simulator spectre
  Models: /class/ece425/FreePDK45/ncsu_basekit/models/hspice/hspice_nom.include
  Temperature: 27
  Stimulus in: voltage bit val1=1 val0=0 delay=0 rise=10p fall=10p period=2.5n srcType=bit data=0000
  Stimulus p_in: voltage bit val1=1 val0=0 delay=0 rise=10p fall=10p period=2.5n srcType=bit data=1111
  Stimulus n_in: voltage bit val1=1 val0=0 delay=0 rise=10p fall=10p period=2.5n srcType=bit data=0101
  Stimulus vdd!: voltage dc dc=1 srcType=dc
  Stimulus vss!: voltage dc dc=0 srcType=dc
  Analysis tran: stop=10n
  Signals: /p_in, /in, /n_in, /out
Run mode: Single Run, Sweeps and Corners
