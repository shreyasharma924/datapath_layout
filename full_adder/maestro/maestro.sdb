ADE simulation setup
Run mode: Single Run, Sweeps and Corners
Tests:
  mp_datapath_full_adder_1: mp_datapath/full_adder/schematic, simulator spectre
