ADE simulation setup
Test mp_datapath_mux4_1: mp_datapath/mux4/schematic, simulator spectre
  Models: /class/ece425/FreePDK45/ncsu_basekit/models/hspice/hspice_nom.include
  Temperature: 27
  Stimulus vss!: voltage dc dc=0 srcType=dc
  Stimulus vdd!: voltage dc dc=1 srcType=dc
  Stimulus IN1: voltage bit val1=1 val0=0 delay=0 rise=10p fall=10p period=2.5n srcType=bit data=0000
  Stimulus IN2: voltage bit val1=1 val0=0 delay=0 rise=10p fall=10p period=2.5n srcType=bit data=1010
  Stimulus IN3: voltage bit val1=1 val0=0 delay=0 rise=10p fall=10p period=2.5n srcType=bit data=0101
  Stimulus S0: voltage bit val1=1 val0=0 delay=0 rise=10p fall=10p period=2.5n srcType=bit data=0001
  Stimulus S1: voltage bit val1=1 val0=0 delay=0 rise=10p fall=10p period=2.5n srcType=bit data=1001
  Stimulus IN0: voltage bit val1=1 val0=0 delay=0 rise=10p fall=10p period=2.5n srcType=bit data=1111
  Analysis tran: stop=10n
  Signals: /IN1, /IN2, /IN3, /S0, /S1, /IN0, /Y
Run mode: Single Run, Sweeps and Corners
