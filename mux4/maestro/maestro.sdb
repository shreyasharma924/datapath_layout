ADE simulation setup
Run mode: Single Run, Sweeps and Corners
Tests:
  mp_datapath_mux4_1: mp_datapath/mux4/schematic, simulator spectre
